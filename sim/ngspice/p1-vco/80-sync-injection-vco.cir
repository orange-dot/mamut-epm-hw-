* 80-sync-injection-vco.cir
* First sync injection study on the integrated chain.
* Sync pulses push the threshold node positive enough to force reset events.

.param CV_IN_DC=0
.param COARSE_V=0
.param FINE_V=0
.param TambC=25

.param Ibase=5u
.param SenseR=100k

.param Kvt=8.617333262145e-5
.param Vt25={Kvt * (25 + 273.15)}
.param VtNow={Kvt * (TambC + 273.15)}
.param ScaleNow={log(2) * (Vt25 / VtNow)}

.param Ctiming=10n
.param Vtrip=1.0
.param Vcomp=5

.param CompOn=0.02
.param CompOff=-0.50
.param CompVt={(CompOn + CompOff) / 2}
.param CompVh={(CompOn - CompOff) / 2}

.param ResetRon=0.1
.param ResetRoff=1e9

.param SyncAmp=0
.param SyncGain=0.35
.param SyncWidth=20u
.param SyncPeriod=700u

Vcv cv_in 0 {CV_IN_DC}
Vsync sync_in 0 PULSE(0 {SyncAmp * Vcomp} 0 100n 100n {SyncWidth} {SyncPeriod})
Bsum tune_sum 0 V = v(cv_in) + {COARSE_V} + {FINE_V}

Bexpo_ramp 0 ramp I = {Ibase * exp(ScaleNow * v(tune_sum))}
Bexpo_sense 0 expo_out I = {Ibase * exp(ScaleNow * v(tune_sum))}
Rsense expo_out 0 {SenseR}

Ctiming ramp 0 {Ctiming} ic=0
Rbleed ramp 0 10Meg

Bthreshold threshold_node 0 V = v(ramp) - {Vtrip} + {SyncGain} * (v(sync_in) / Vcomp)

Vhi hi 0 {Vcomp}
Rpullcomp reset_ctrl 0 10k
Scomp hi reset_ctrl threshold_node 0 SWCOMP
.model SWCOMP SW(Ron=1 Roff=1e9 Vt={CompVt} Vh={CompVh})

Sreset ramp 0 reset_ctrl 0 SWRST
.model SWRST SW(Ron={ResetRon} Roff={ResetRoff} Vt=2.5 Vh=0.5)

Bsaw saw_out 0 V = v(ramp)
Bpulse pulse_out 0 V = v(reset_ctrl)

.tran 1u 12m uic maxstep=1u

.control
set filetype=ascii

let sync_state = unitvec(2)
let periods = unitvec(2)
let freqs = unitvec(2)

alterparam SyncAmp = 0
reset
run
wrdata 80-sync-injection-off.csv time v(sync_in) v(ramp) v(threshold_node) v(reset_ctrl) v(saw_out)
meas tran period_off trig v(reset_ctrl) val=2.5 rise=3 targ v(reset_ctrl) val=2.5 rise=4
let sync_state[0] = 0
let periods[0] = period_off
let freqs[0] = 1 / period_off

alterparam SyncAmp = 1
reset
run
wrdata 80-sync-injection-on.csv time v(sync_in) v(ramp) v(threshold_node) v(reset_ctrl) v(saw_out)
meas tran period_on trig v(reset_ctrl) val=2.5 rise=3 targ v(reset_ctrl) val=2.5 rise=4
let sync_state[1] = 1
let periods[1] = period_on
let freqs[1] = 1 / period_on

print sync_state periods freqs > 80-sync-injection-summary.txt
.endc

.end
